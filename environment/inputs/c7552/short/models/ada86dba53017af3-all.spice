* SKY130 Spice File.
.option scale=1.0u
.include "6200b50c14eebb68-lod.spice"
.param
+ lv_dlc_rotweak = .00e-9
+ lvhvt_dlc_rotweak = .00e-9
+ lvt_dlc_rotweak = .00e-9
+ hv_dlc_rotweak = .00e-9
+ sky130_fd_pr__nfet_01v8__dlc_rotweak = lv_dlc_rotweak
+ sky130_fd_pr__esd_nfet_01v8__dlc_rotweak = lv_dlc_rotweak
+ sky130_fd_pr__nfet_01v8_lvt__dlc_rotweak = lvt_dlc_rotweak
+ sky130_fd_pr__pfet_01v8__dlc_rotweak = lv_dlc_rotweak
+ sky130_fd_pr__pfet_01v8_lvt__dlc_rotweak = lvt_dlc_rotweak
+ sky130_fd_pr__pfet_01v8_hvt__dlc_rotweak = lvhvt_dlc_rotweak
+ sky130_fd_pr__esd_nfet_g5v0d10v5__dlc_rotweak = hv_dlc_rotweak
+ sky130_fd_pr__esd_pfet_g5v0d10v5__dlc_rotweak = hv_dlc_rotweak
+ sky130_fd_pr__nfet_03v3_nvt__dlc_rotweak = hv_dlc_rotweak
+ sky130_fd_pr__nfet_05v0_nvt__dlc_rotweak = hv_dlc_rotweak
+ sky130_fd_pr__nfet_g5v0d10v5__dlc_rotweak = hv_dlc_rotweak
+ sky130_fd_pr__pfet_g5v0d10v5__dlc_rotweak = hv_dlc_rotweak
+ sky130_fd_pr__pfet_g5v0d16v0__dlc_rotweak = hv_dlc_rotweak
+ sky130_fd_pr__special_nfet_pass__dlc_rotweak = lv_dlc_rotweak
+ sky130_fd_pr__special_nfet_pass_lowleakage__dlc_rotweak = lv_dlc_rotweak
+ sky130_fd_pr__special_nfet_pass_flash__dlc_rotweak = hv_dlc_rotweak
+ sky130_fd_pr__special_nfet_latch__dlc_rotweak = lv_dlc_rotweak
+ sky130_fd_pr__special_nfet_latch_lowleakage__dlc_rotweak = lv_dlc_rotweak
+ sky130_fd_pr__special_pfet_latch__dlc_rotweak = lv_dlc_rotweak
+ sky130_fd_pr__special_pfet_latch_lowleakage__dlc_rotweak = lv_dlc_rotweak
+ sky130_fd_bs_flash__special_sonosfet_star__dlc_rotweak = hv_dlc_rotweak
+ sky130_fd_bs_flash__special_sonosfet_original__dlc_rotweak = hv_dlc_rotweak
+ sonos_eeol_dlc_rotweak = hv_dlc_rotweak
+ sonos_peol_dlc_rotweak = hv_dlc_rotweak
* include all individual diode models
.include "3576794a3db5dd40-sky130_fd_pr__model__parasitic__diode_ps2nw.model.spice"
.include "ca6cc52ed9449e0e-sky130_fd_pr__diode_pw2nd_05v5.model.spice"
.include "991227f64be92e63-sky130_fd_pr__diode_pd2nw_05v5.model.spice"
.include "9f3b9a028e7e4dd5-sky130_fd_pr__diode_pd2nw_05v5_hvt.model.spice"
.include "47c33e82bd01f8a5-sky130_fd_pr__diode_pw2nd_11v0.model.spice"
.include "3134e9ffc310d89e-sky130_fd_pr__diode_pd2nw_11v0.model.spice"
.include "f6e4452b10e6d389-sky130_fd_pr__diode_pw2nd_05v5_nvt.model.spice"
.include "b303be24a4a7897e-sky130_fd_pr__diode_pw2nd_05v5_lvt.model.spice"
.include "02c4cf2e034e5f0b-sky130_fd_pr__diode_pd2nw_05v5_lvt.model.spice"
.include "cfad4923ff030d97-sky130_fd_pr__model__parasitic__diode_pw2dn.model.spice"
.include "47f9c12a2ff58b56-sky130_fd_pr__model__parasitic__diode_ps2dn.model.spice"
.include "becc765e76e24279-sky130_fd_pr__pfet_g5v0d16v0__parasitic__diode_pw2dn.model.spice"
* call models applicable to any corner
.include "512f1b81a1b09382-sky130_fd_pr__pnp_05v5_W0p68L0p68.model.spice"
.include "c77f3564d71b285d-sky130_fd_pr__pnp_05v5_W3p40L3p40.model.spice"
.include "02f9057ac1ba5dc1-sky130_fd_pr__npn_05v5_W1p00L1p00.model.spice"
.include "e37da16e95b99120-sky130_fd_pr__npn_05v5_W1p00L2p00.model.spice"
.include "1ce8a924194dbdbb-sky130_fd_pr__npn_11v0_W1p00L1p00.model.spice"
.include "f61567098b8dcc89-sky130_fd_pr__pfet_g5v0d16v0.pm3.spice"
.include "1e0c19100db1bb3f-sky130_fd_pr__pfet_g5v0d16v0__subcircuit.pm3.spice"
.include "ef07259bd556443e-sky130_fd_pr__cap_var_lvt.model.spice"
.include "450b49b213811b23-sky130_fd_pr__cap_var_hvt.model.spice"
.include "9cce1db3f8aba6fb-sky130_fd_pr__res_iso_pw.model.spice"
.include "7f0bf5a9d06a65f5-sky130_fd_pr__cap_vpp_08p6x07p8_l1m1m2_noshield_o1.model.spice"
.include "7e4802d7047f0f11-sky130_fd_pr__model__cap_mim.model.spice"
.include "7daca9f9743d93a4-sky130_fd_pr__model__cap_vpp_only_mos.model.spice"
.include "051c18598854776f-mm.spice"
.include "8a4c2d8b90947a09-mm.spice"
*.include "hspice.par"
.include "0c2499173f578cf0-head.spice"
.include "065c3a36cd891edc-sky130_fd_pr__special_nfet_pass.pm3.spice"
.include "634af21934ab8f08-sky130_fd_pr__special_nfet_latch.pm3.spice"
.include "a71d8e707ff90f4e-sky130_fd_pr__special_pfet_latch.pm3.spice"
.include "484f90f58677ce58-sky130_fd_pr__special_nfet_pass_flash.pm3.spice"
.include "ec9f9f3796d17696-sky130_fd_pr__model__cap_vpp_only_pq.model.spice"
.include "80cf9e98c6d05ff2-sky130_fd_pr__model__cap_vpp_only_p.model.spice"
.include "881a81256ed63b13-sky130_fd_pr__model__linear.model.spice"
.param sky130_fd_pr__rf_nfet_01v8_lvt__base__dlc_rotweak=0
.param sky130_fd_pr__pfet_01v8_lvt__rf_base_dlc_rotweak=0
.param sky130_fd_pr__rf_nfet_01v8__base__dlc_rotweak=0
.param sky130_fd_pr__rf_pfet_01v8__base__dlc_rotweak=0
.param sky130_fd_pr__rf_nfet_g5v0d10v5__base__dlc_rotweak=0
.include "cc1cd3b324345059-sky130_fd_pr__rf_nfet_g5v0d10v5.pm3.spice"
.include "0bb1e7a3df76f120-sky130_fd_pr__rf_nfet_01v8_lvt.pm3.spice"
.include "dd1d04c190d31692-sky130_fd_pr__rf_nfet_01v8.pm3.spice"
.include "089d6c9a4cc5fc7a-sky130_fd_pr__rf_pfet_01v8.pm3.spice"
.include "c199498330766566-sky130_fd_pr__rf_pfet_01v8_mvt.pm3.spice"
