* SKY130 Spice File.
.include "4a70607ef6e016b4-sky130_fd_pr__nfet_01v8__ss.pm3.spice"
.include "24a3b29d7d7f26f9-sky130_fd_pr__nfet_01v8__mismatch.corner.spice"
.include "23eb2d35ada169b3-sky130_fd_pr__nfet_01v8_lvt__ss.corner.spice"
.include "1855038a2ad2fe39-sky130_fd_pr__nfet_01v8_lvt__mismatch.corner.spice"
.include "8d8b59726b48aa7a-sky130_fd_pr__pfet_01v8__ss.corner.spice"
.include "f4d560668712678e-sky130_fd_pr__pfet_01v8__mismatch.corner.spice"
.include "a7e9ecf9dad2a681-sky130_fd_pr__nfet_03v3_nvt__ss.corner.spice"
.include "fd3813731a14eb0c-sky130_fd_pr__nfet_03v3_nvt__mismatch.corner.spice"
.include "47dcdf2c517f75df-sky130_fd_pr__nfet_05v0_nvt__ss.corner.spice"
.include "4c1ce4d79656afd5-sky130_fd_pr__nfet_05v0_nvt__mismatch.corner.spice"
.include "e68650b0bd8e3765-sky130_fd_pr__esd_nfet_01v8__ss.corner.spice"
.include "838e42d3bd0394b0-sky130_fd_pr__pfet_01v8_lvt__ss.corner.spice"
.include "6fa9be51a32f2f66-sky130_fd_pr__pfet_01v8_lvt__mismatch.corner.spice"
.include "ec4f1b79d6dc56c4-sky130_fd_pr__pfet_01v8_hvt__ss.pm3.spice"
.include "05e258ab6724c827-sky130_fd_pr__pfet_01v8_hvt__mismatch.corner.spice"
.include "5913c622d254d677-sky130_fd_pr__esd_pfet_g5v0d10v5__ss.corner.spice"
.include "171fe57846f7562c-sky130_fd_pr__pfet_g5v0d10v5__ss.corner.spice"
.include "7564bd6e8ba2e7a1-sky130_fd_pr__pfet_g5v0d10v5__mismatch.corner.spice"
.include "7ae02c1c3aaf0c09-sky130_fd_pr__pfet_g5v0d16v0__ss.corner.spice"
.include "5b2ef445a9fa6f86-sky130_fd_pr__nfet_g5v0d10v5__ss.corner.spice"
.include "e4124d91feee11f9-sky130_fd_pr__nfet_g5v0d10v5__mismatch.corner.spice"
.include "4608d0b5f2296691-sky130_fd_pr__nfet_g5v0d16v0__ss_discrete.corner.spice"
.include "92ca30e89fb3873a-sky130_fd_pr__esd_nfet_g5v0d10v5__ss.corner.spice"
.include "7aa4c20bf9cc7d8e-nonfet.spice"
.include "c22b2c86558d22e7-sky130_fd_pr__pfet_20v0__sf_discrete.corner.spice"
.include "6f8acc38821304a8-sky130_fd_pr__nfet_20v0__fs_discrete.corner.spice"
.include "23e9c408698a7632-sky130_fd_pr__nfet_20v0_nvt__fs_discrete.corner.spice"
.include "7fbf55b3c6092f6b-sky130_fd_pr__npn_05v5__s.corner.spice"
.include "ada86dba53017af3-all.spice"
.include "a84b63c6204a7b9e-rf.spice"
