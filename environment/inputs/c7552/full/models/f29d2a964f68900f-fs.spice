* SKY130 Spice File.
.include "85f26c62c5c6ce31-sky130_fd_pr__nfet_01v8__fs.pm3.spice"
.include "24a3b29d7d7f26f9-sky130_fd_pr__nfet_01v8__mismatch.corner.spice"
.include "b44b14281fb42ca6-sky130_fd_pr__nfet_01v8_lvt__fs.corner.spice"
.include "1855038a2ad2fe39-sky130_fd_pr__nfet_01v8_lvt__mismatch.corner.spice"
.include "b3dc4e47f87a780e-sky130_fd_pr__pfet_01v8__fs.corner.spice"
.include "f4d560668712678e-sky130_fd_pr__pfet_01v8__mismatch.corner.spice"
.include "8925259365575206-sky130_fd_pr__nfet_03v3_nvt__fs.corner.spice"
.include "fd3813731a14eb0c-sky130_fd_pr__nfet_03v3_nvt__mismatch.corner.spice"
.include "e5d71444f6197118-sky130_fd_pr__nfet_05v0_nvt__fs.corner.spice"
.include "4c1ce4d79656afd5-sky130_fd_pr__nfet_05v0_nvt__mismatch.corner.spice"
.include "b2da31294d07c4ce-sky130_fd_pr__esd_nfet_01v8__fs.corner.spice"
.include "53eefa3929c61289-sky130_fd_pr__pfet_01v8_lvt__fs.corner.spice"
.include "6fa9be51a32f2f66-sky130_fd_pr__pfet_01v8_lvt__mismatch.corner.spice"
.include "2e59b0a4a07f3411-sky130_fd_pr__pfet_01v8_hvt__fs.pm3.spice"
.include "05e258ab6724c827-sky130_fd_pr__pfet_01v8_hvt__mismatch.corner.spice"
.include "386d64641dcc97da-sky130_fd_pr__esd_pfet_g5v0d10v5__fs.corner.spice"
.include "914a77dd766de318-sky130_fd_pr__pfet_g5v0d10v5__fs.corner.spice"
.include "7564bd6e8ba2e7a1-sky130_fd_pr__pfet_g5v0d10v5__mismatch.corner.spice"
.include "79c2d084e6cc9db6-sky130_fd_pr__pfet_g5v0d16v0__fs.corner.spice"
.include "00c599d50c81e8a5-sky130_fd_pr__nfet_g5v0d10v5__fs.corner.spice"
.include "e4124d91feee11f9-sky130_fd_pr__nfet_g5v0d10v5__mismatch.corner.spice"
.include "6ded3c7b9b92e8d8-sky130_fd_pr__nfet_g5v0d16v0__fs_discrete.corner.spice"
.include "979da8a91772e6d2-sky130_fd_pr__esd_nfet_g5v0d10v5__fs.corner.spice"
.include "739c7e8da3ef68d2-nonfet.spice"
.include "835aa506b3d5e671-sky130_fd_pr__pfet_20v0__fs_discrete.corner.spice"
.include "6f8acc38821304a8-sky130_fd_pr__nfet_20v0__fs_discrete.corner.spice"
.include "23e9c408698a7632-sky130_fd_pr__nfet_20v0_nvt__fs_discrete.corner.spice"
.include "625e1d8028c8d3e5-sky130_fd_pr__npn_05v5__t.corner.spice"
.include "ada86dba53017af3-all.spice"
.include "98e15ab2e4df9c45-rf.spice"
