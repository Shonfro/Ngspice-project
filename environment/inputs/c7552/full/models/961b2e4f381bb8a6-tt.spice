* SKY130 Spice File.
.include "459eca963a134574-sky130_fd_pr__nfet_01v8__tt.pm3.spice"
.include "24a3b29d7d7f26f9-sky130_fd_pr__nfet_01v8__mismatch.corner.spice"
.include "716b48c11275bb1e-sky130_fd_pr__nfet_01v8_lvt__tt.corner.spice"
.include "1855038a2ad2fe39-sky130_fd_pr__nfet_01v8_lvt__mismatch.corner.spice"
.include "641d251a08bf9ddc-sky130_fd_pr__pfet_01v8__tt.corner.spice"
.include "f4d560668712678e-sky130_fd_pr__pfet_01v8__mismatch.corner.spice"
.include "6ac550dbda38845d-sky130_fd_pr__nfet_03v3_nvt__tt.corner.spice"
.include "fd3813731a14eb0c-sky130_fd_pr__nfet_03v3_nvt__mismatch.corner.spice"
.include "ad6f98b01ba312f9-sky130_fd_pr__nfet_05v0_nvt__tt.corner.spice"
.include "4c1ce4d79656afd5-sky130_fd_pr__nfet_05v0_nvt__mismatch.corner.spice"
.include "2fe2461e85a325fc-sky130_fd_pr__esd_nfet_01v8__tt.corner.spice"
.include "ddb3ddcd4ccb85c1-sky130_fd_pr__pfet_01v8_lvt__tt.corner.spice"
.include "6fa9be51a32f2f66-sky130_fd_pr__pfet_01v8_lvt__mismatch.corner.spice"
.include "3a1be2e1c50d710b-sky130_fd_pr__pfet_01v8_hvt__tt.pm3.spice"
.include "05e258ab6724c827-sky130_fd_pr__pfet_01v8_hvt__mismatch.corner.spice"
.include "ceed8cc24d9ec029-sky130_fd_pr__esd_pfet_g5v0d10v5__tt.corner.spice"
.include "52707b9324655140-sky130_fd_pr__pfet_g5v0d10v5__tt.corner.spice"
.include "7564bd6e8ba2e7a1-sky130_fd_pr__pfet_g5v0d10v5__mismatch.corner.spice"
.include "a4d9c6839b8668a0-sky130_fd_pr__pfet_g5v0d16v0__tt.corner.spice"
.include "c6220fd1b3ed0090-sky130_fd_pr__nfet_g5v0d10v5__tt.corner.spice"
.include "e4124d91feee11f9-sky130_fd_pr__nfet_g5v0d10v5__mismatch.corner.spice"
.include "4345c8cad35b7e1b-sky130_fd_pr__nfet_g5v0d16v0__tt_discrete.corner.spice"
.include "61500e742b5dd0eb-sky130_fd_pr__esd_nfet_g5v0d10v5__tt.corner.spice"
.include "9e442b3828f29c8c-nonfet.spice"
.include "437039ebf2762d9f-sky130_fd_pr__nfet_20v0__tt_discrete.corner.spice"
.include "3027fce9091c0cdd-sky130_fd_pr__pfet_20v0__tt_discrete.corner.spice"
.include "8a4e88bcbce811f3-sky130_fd_pr__nfet_20v0_nvt__tt_discrete.corner.spice"
.include "625e1d8028c8d3e5-sky130_fd_pr__npn_05v5__t.corner.spice"
.include "ada86dba53017af3-all.spice"
.include "9bba9a4521426fb2-rf.spice"
