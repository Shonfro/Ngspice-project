* SKY130 Spice File.
.include "f0a46f156adb47c6-sky130_fd_pr__nfet_01v8__sf.pm3.spice"
.include "24a3b29d7d7f26f9-sky130_fd_pr__nfet_01v8__mismatch.corner.spice"
.include "5e4122da6a18aca5-sky130_fd_pr__nfet_01v8_lvt__sf.corner.spice"
.include "1855038a2ad2fe39-sky130_fd_pr__nfet_01v8_lvt__mismatch.corner.spice"
.include "857ce650534be04b-sky130_fd_pr__pfet_01v8__sf.corner.spice"
.include "f4d560668712678e-sky130_fd_pr__pfet_01v8__mismatch.corner.spice"
.include "cd6e52b931d54b3d-sky130_fd_pr__nfet_03v3_nvt__sf.corner.spice"
.include "fd3813731a14eb0c-sky130_fd_pr__nfet_03v3_nvt__mismatch.corner.spice"
.include "070556259bde129f-sky130_fd_pr__nfet_05v0_nvt__sf.corner.spice"
.include "4c1ce4d79656afd5-sky130_fd_pr__nfet_05v0_nvt__mismatch.corner.spice"
.include "95fa572dc223518c-sky130_fd_pr__esd_nfet_01v8__sf.corner.spice"
.include "96f4ed1667765219-sky130_fd_pr__pfet_01v8_lvt__sf.corner.spice"
.include "6fa9be51a32f2f66-sky130_fd_pr__pfet_01v8_lvt__mismatch.corner.spice"
.include "4b9ec19b7681511f-sky130_fd_pr__pfet_01v8_hvt__sf.pm3.spice"
.include "05e258ab6724c827-sky130_fd_pr__pfet_01v8_hvt__mismatch.corner.spice"
.include "4fd874922e81055e-sky130_fd_pr__esd_pfet_g5v0d10v5__sf.corner.spice"
.include "64d84750c79144bc-sky130_fd_pr__pfet_g5v0d10v5__sf.corner.spice"
.include "7564bd6e8ba2e7a1-sky130_fd_pr__pfet_g5v0d10v5__mismatch.corner.spice"
.include "5f7ce22905a1aff0-sky130_fd_pr__pfet_g5v0d16v0__sf.corner.spice"
.include "93fdae80469c761f-sky130_fd_pr__nfet_g5v0d10v5__sf.corner.spice"
.include "e4124d91feee11f9-sky130_fd_pr__nfet_g5v0d10v5__mismatch.corner.spice"
.include "40d2f37f470698e0-sky130_fd_pr__nfet_g5v0d16v0__sf_discrete.corner.spice"
.include "e2c0ccda525494a8-sky130_fd_pr__esd_nfet_g5v0d10v5__sf.corner.spice"
.include "4f790eb5083d1e20-nonfet.spice"
.include "c22b2c86558d22e7-sky130_fd_pr__pfet_20v0__sf_discrete.corner.spice"
.include "86c6b605f6748542-sky130_fd_pr__nfet_20v0__sf_discrete.corner.spice"
.include "9a7208e7fcba94cd-sky130_fd_pr__nfet_20v0_nvt__sf_discrete.corner.spice"
.include "625e1d8028c8d3e5-sky130_fd_pr__npn_05v5__t.corner.spice"
.include "ada86dba53017af3-all.spice"
.include "98b843ee3f6d0bd7-rf.spice"
