* SKY130 Spice File.
.include "abbf671996e76bf3-sky130_fd_pr__nfet_01v8__ff.pm3.spice"
.include "24a3b29d7d7f26f9-sky130_fd_pr__nfet_01v8__mismatch.corner.spice"
.include "e84da569821a546b-sky130_fd_pr__nfet_01v8_lvt__ff.corner.spice"
.include "1855038a2ad2fe39-sky130_fd_pr__nfet_01v8_lvt__mismatch.corner.spice"
.include "30ba71bde4024ff2-sky130_fd_pr__pfet_01v8__ff.corner.spice"
.include "f4d560668712678e-sky130_fd_pr__pfet_01v8__mismatch.corner.spice"
.include "0fdaf141f890121d-sky130_fd_pr__nfet_03v3_nvt__ff.corner.spice"
.include "fd3813731a14eb0c-sky130_fd_pr__nfet_03v3_nvt__mismatch.corner.spice"
.include "2adc32d1c5f38df8-sky130_fd_pr__nfet_05v0_nvt__ff.corner.spice"
.include "4c1ce4d79656afd5-sky130_fd_pr__nfet_05v0_nvt__mismatch.corner.spice"
.include "0206cc43047aaa9f-sky130_fd_pr__esd_nfet_01v8__ff.corner.spice"
.include "4be6d4c6ee9e4ffc-sky130_fd_pr__pfet_01v8_lvt__ff.corner.spice"
.include "6fa9be51a32f2f66-sky130_fd_pr__pfet_01v8_lvt__mismatch.corner.spice"
.include "d67e1b0f7f379ea4-sky130_fd_pr__pfet_01v8_hvt__ff.pm3.spice"
.include "05e258ab6724c827-sky130_fd_pr__pfet_01v8_hvt__mismatch.corner.spice"
.include "5a21d27681490ef9-sky130_fd_pr__esd_pfet_g5v0d10v5__ff.corner.spice"
.include "70c2630c319f9856-sky130_fd_pr__pfet_g5v0d10v5__ff.corner.spice"
.include "7564bd6e8ba2e7a1-sky130_fd_pr__pfet_g5v0d10v5__mismatch.corner.spice"
.include "be86f65df2282558-sky130_fd_pr__pfet_g5v0d16v0__ff.corner.spice"
.include "23e17fb740ff03ff-sky130_fd_pr__nfet_g5v0d10v5__ff.corner.spice"
.include "e4124d91feee11f9-sky130_fd_pr__nfet_g5v0d10v5__mismatch.corner.spice"
.include "7e258c446bbdcac9-sky130_fd_pr__nfet_g5v0d16v0__ff_discrete.corner.spice"
.include "b5cc17d0ccaced82-sky130_fd_pr__esd_nfet_g5v0d10v5__ff.corner.spice"
.include "d03e3604898888b6-nonfet.spice"
.include "835aa506b3d5e671-sky130_fd_pr__pfet_20v0__fs_discrete.corner.spice"
.include "86c6b605f6748542-sky130_fd_pr__nfet_20v0__sf_discrete.corner.spice"
.include "9a7208e7fcba94cd-sky130_fd_pr__nfet_20v0_nvt__sf_discrete.corner.spice"
.include "0bbd20b5b08c2cc9-sky130_fd_pr__npn_05v5__f.corner.spice"
.include "ada86dba53017af3-all.spice"
.include "393419a64b47329d-rf.spice"
